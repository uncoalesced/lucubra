* First-order low-pass RC network
V1 in 0 AC 1 PULSE(0 5 0 1n 1n 5m 10m)
R1 in out 1k
C1 out 0 100n
.tran 0.1ms 10ms
.ac dec 10 10 100k
.end
